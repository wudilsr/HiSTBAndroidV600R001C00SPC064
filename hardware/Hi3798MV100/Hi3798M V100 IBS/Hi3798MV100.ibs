|   IBIS model for hi3798mv100
[IBIS ver]   4.1
[Comment char]  |_char
[File name]   hi3798mv100.ibs
[File Rev]   1.0
[Date]   May 5,2014
[Source]   HISILICON TECHNOLOGIES CO., LTD.
[Notes]
|[Disclaimer]   HISILICON TECHNOLOGIES CO., LTD. hereby grants the
| *   user of this IBIS model a non-exclusive, nontransferable
|*   license to use this IBIS model under the following terms.
|*   The user is granted this license only to use the IBIS model
|*   and is not granted rights to sell, copy (except as needed to
|*   run the IBIS model), rent, lease or sub-license the IBIS
|*   model in whole or in part, or in modified form to anyone. The
|*   User may modify the IBIS model to suit its specific applicati
|*   ons, but rights to derivative works and such modifications sh
|*   all belong to Hisilicon. This IBIS model is provided on an
|*   "ASIS" basis and Hisilicon  makes absolutely no warranty with
|*   respect to the information contained herein. HISILICON DISCLAI
|*   MS AND CUSTOMER WAIVES ALL WARRANTIES, EXPRESS AND IMPLIED, IN
|*   CLUDING WARRANTIES OF MERCHANTABILITY AND FITNESS FOR A PARTIC
|*   ULAR PURPOSE. THE ENTIRE RISK AS TO QUALITY AND PERFORMANCE IS
|*   WITH THE USER ACCORDINGLY, IN NO EVENT SHALL HISILICON BE LIAB
|*   LE FOR ANY DIRECT OR INDIRECT DAMAGES, WHETHER IN CONTRACT OR
|*   TORT, INCLUDING ANY LOST PROFITS OR OTHER INCIDENTAL, CONSEQUEN
|*   TIAL, EXEMPLARY, OR PUNITIVE DAMAGES ARISING OUT OF THE USE OR
|*   APPLICATION OF THE IBIS MODEL. Further, Hisilicon reserves the
|*   right to make changes without notice to any product herein to
|*   improve reliability,fnction, or design. Hisilicon does not convey
|*   any license under patent rights or any other intellectual property
|*   rights, including those of third parties. Hisilicon is not obligated
|*   to provide maintenance or support for the licensed IBIS model.
|*[Copyright]  Copyright 2013,HISILICON TECHNOLOGIES CO., LTD.
|*   all rights reserved
|*Author   : liuhailong   *****/
||****************************************************************************/
|   IBIS model for hi3798mv100
|   Component hi3798mv100_BGA
[Component]   hi3798mv100
[Manufacturer]   hisi inc.
[Package]
| variable   typ   min   max
R_pkg   450mohm   400mohm   500mohm
L_pkg   8nH   6nH   10nH
C_pkg   2.0pF   1.5pF   2.5pF
[Pin]  signal_name   model_name   R_pin   L_pin   C_pin
1	LED_CLK   PRDW4DDGZ_L
2	LED_DATA		PRDW4DDGZ_L
3	SIM0_CLK		PRDW4DDGZ_L
4	SIM0_DET		PRDW4DSCDG_L
5	SIM0_DATA		PRDW4DDGZ_L
6	FUNC_SEL		PRDW4DSCDG_L
7	LED_KEY0		PRDW4DDGZ_L
8	SIM0_PWREN		PRDW4DDGZ_L
9	SIM0_RST		PRDW4DDGZ_L
10	IR_IN   PRUW4DSDGZ_L
11	STANDBY_PWROFF		PRDW4DCDG_L
12	UART0_RXD		PRDW4DDGZ_L
13	UART0_TXD	 	PRDW4DDGZ_L
14	XIN   PX3RNC_XIN
15	XOUT   PX3RNC_XOUT
16	EBI_DQ7   PRUW8DSCDG
17	EBI_DQ6   PRDW8DCDG
18	EBI_DQ5   PRDW8DCDG
19	EBI_DQ4   PRDW8DCDG
20	EBI_DQ3   PRDW8DCDG
21	EBI_DQ2   PRDW8DCDG
22	EBI_DQ1   PRDW8DCDG
23	EBI_DQ0   PRDW8DCDG
24	NF_WEN   PRDW4DCDG_L
25	NF_ALE   PRDW4DCDG_L
26	NF_CLE   PRDW4DCDG_L
27	NF_CSN0   PRUKW8DCDG
28	NF_REN   PRDW8DCDG
29	NF_RDY0   PRUKW4DSCDG_L
30	JTAG_TMS		PRUW4DSCDG_L
31	JTAG_TRSTN		PRDW4DSCDG_L
32	JTAG_TCK		PRDW4DSCDG_L
33	JTAG_TDI		PRUW4DSCDG_L
34	JTAG_TDO		PRDW4DCDG_L
35	TSI0_D2   PRDW4DCDG_L
36	TSI0_D1   PRDW4DCDG_L
37	TSI0_D0   PRDW4DCDG_L
38	TSI0_CLK		PRDW4DCDG_L
39	TSI0_VALID	 	PRDW4DCDG_L
40	I2C2_SCL		PRDW4DSDGZ_L
41	I2C2_SDA		PRDW4DSDGZ_L
42	USB_BOOT		PRUW4DSCDG_L
43	DEM_RST   PRDW4DCDG_L
44	I2C0_SCL		PRDW4DSDGZ_L
45	I2C0_SDA		PRDW4DSDGZ_L
46	JTAG_SEL		PRDW4DSCDG_L
47	MUTE_CTRL		PRDW4DCDG_L
48	SPDIF_OUT		PRDW4DSCDG_L
49	HDMITX_HOTPLUG		PRDW4DSDGZ_L
50	CABOOT_EN		PRDW4DSCDG_L
51	HDMITX_SDA		PRDW4DSDGZ_L
52	HDMITX_SCL		PRDW4DSDGZ_L
53	HDMITX_CEC		PRDW4DSCDG_L
54	SPI_SCLK		PRDW4DDGZ_L
55	SPI_SDO   PRDW4DDGZ_L
56	SPI_SDI   PRDW4DDGZ_L
57	SPI_CSN0		PRDW4DDGZ_L
58	SPI_CSN1		PRDW4DCDG_L
59	SLIC_RST		PRDW4DCDG_L
60	I2S0_BCLK		PRDW4DCDG_L
61	I2S0_WS   PRDW4DCDG_L
62	I2S0_DOUT0		PRDW4DCDG_L
63	I2S0_MCLK		PRDW4DCDG_L
64	I2S0_DIN0		PRDW4DCDG_L
65	FE_LED_ACT		PRDW4DDGZ_L
66	FE_LED_BASE		PRDW4DDGZ_L
67	SDIO0_CWPR   PRDW4DCDG_L
68	SDIO0_CDATA1		PRDW8DCDG
69	SDIO0_CDATA0		PRDW8DCDG
70	SDIO0_CCLK_OUT		PRDW8DCDG_H
71	SDIO0_CCMD		PRDW8DCDG
72	SDIO0_CDATA3		PRDW8DCDG
73	SDIO0_CDATA2		PRDW8DCDG
74	SDIO0_CARD_DETECT	PRDW4DCDG_L
75	SDIO0_CARD_POWER_EN	PRDW4DCDG_L
76	DDR_DQ6   PDDRSIO_ISOG
77	DDR_DQ2   PDDRSIO_ISOG
78	DDR_DQ4   PDDRSIO_ISOG
79	DDR_DQ0   PDDRSIO_ISOG
80	DDR_DQ11		PDDRSIO_ISOG
81	DDR_DQ9   PDDRSIO_ISOG
82	DDR_DQ13		PDDRSIO_ISOG
83	DDR_DQ15		PDDRSIO_ISOG
84	DDR_DQS0		PDDRDIO_IGOS
85	DDR_DQSB0		PDDRDIO_IGOS
86	DDR_DQS1		PDDRDIO_IGOS
87	DDR_DQSB1		PDDRDIO_IGOS
88	DDR_DM0   PDDRSIO_ISOG
89	DDR_DM1   PDDRSIO_ISOG
90	DDR_DQ8   PDDRSIO_ISOG
91	DDR_DQ10		PDDRSIO_ISOG
92	DDR_DQ12		PDDRSIO_ISOG
93	DDR_DQ14		PDDRSIO_ISOG
94	DDR_DQ1   PDDRSIO_ISOG
95	DDR_DQ3   PDDRSIO_ISOG
96	DDR_DQ7   PDDRSIO_ISOG
97	DDR_DQ5   PDDRSIO_ISOG
98	DDR_DQ22		PDDRSIO_ISOG
99	DDR_DQ18		PDDRSIO_ISOG
100	DDR_DQ20		PDDRSIO_ISOG
101	DDR_DQ16		PDDRSIO_ISOG
102	DDR_DQ27		PDDRSIO_ISOG
103	DDR_DQ25		PDDRSIO_ISOG
104	DDR_DQ29		PDDRSIO_ISOG
105	DDR_DQ31		PDDRSIO_ISOG
106	DDR_DQS2		PDDRDIO_IGOS
107	DDR_DQSB2		PDDRDIO_IGOS
108	DDR_DQS3		PDDRDIO_IGOS
109	DDR_DQSB3		PDDRDIO_IGOS
110	DDR_DM2   PDDRSIO_ISOG
111	DDR_DM3   PDDRSIO_ISOG
112	DDR_DQ28		PDDRSIO_ISOG
113	DDR_DQ30		PDDRSIO_ISOG
114	DDR_DQ26		PDDRSIO_ISOG
115	DDR_DQ24		PDDRSIO_ISOG
116	DDR_DQ17		PDDRSIO_ISOG
117	DDR_DQ19		PDDRSIO_ISOG
118	DDR_DQ23		PDDRSIO_ISOG
119	DDR_DQ21		PDDRSIO_ISOG
120	DDR_CK1   PDDRDIO_IGOS
121	DDR_CKB1		PDDRDIO_IGOS
122	DDR_CK0   PDDRDIO_IGOS
123	DDR_CKB0		PDDRDIO_IGOS
124	DDR_CKE   PDDRSIO_ISOG
125	DDR_ADDR10		PDDRSIO_ISOG
126	DDR_ADDR12		PDDRSIO_ISOG
127	DDR_BA1   PDDRSIO_ISOP
128	DDR_ADDR4		PDDRSIO_ISOP
129	DDR_ADDR1		PDDRSIO_ISOG
130	DDR_ADDR6		PDDRSIO_ISOG
131	DDR_ADDR8		PDDRSIO_ISOG
132	DDR_ADDR14		PDDRSIO_ISOG
133	DDR_ADDR11		PDDRSIO_ISOG
134	DDR_BA2   PDDRSIO_ISOG
135	DDR_CS0   PDDRSIO_ISOG
136	DDR_ADDR15		PDDRSIO_ISOG
137	DDR_ADDR9		PDDRSIO_ISOG
138	DDR_RESETN		PDDRSIO_ISOG
139	DDR_CAS   PDDRSIO_ISOG
140	DDR_WE   PDDRSIO_ISOG
141	DDR_ADDR3		PDDRSIO_ISOG
142	DDR_ADDR0		PDDRSIO_ISOG
143	DDR_ADDR2		PDDRSIO_ISOG
144	DDR_ADDR13		PDDRSIO_ISOG
145	DDR_BA0   PDDRSIO_ISOG
146	DDR_ODT0		PDDRSIO_ISOG
147	DDR_ADDR7		PDDRSIO_ISOG
148	DDR_ADDR5		PDDRSIO_ISOG
149	DDR_RAS   PDDRSIO_ISOP
|   Model Selector
[Model Selector] PDDRSIO_ISOG
hi_drv3_3420   Driving, Z0=34-Ohms, Rload=20-Ohms
hi_drv3_3430   Driving, Z0=34-Ohms, Rload=30-Ohms
hi_drv3_3440   Driving, Z0=34-Ohms, Rload=40-Ohms
hi_drv3_3460   Driving, Z0=34-Ohms, Rload=60-Ohms
hi_drv3_34120   Driving, Z0=34-Ohms, Rload=120-Ohms
hi_drv3_4020   Driving, Z0=40-Ohms, Rload=20-Ohms
hi_drv3_4030   Driving, Z0=40-Ohms, Rload=30-Ohms
hi_drv3_4040   Driving, Z0=40-Ohms, Rload=40-Ohms
hi_drv3_4060   Driving, Z0=40-Ohms, Rload=60-Ohms
hi_drv3_40120   Driving, Z0=40-Ohms, Rload=120-Ohms
hi_drv3_6020   Driving, Z0=60-Ohms, Rload=20-Ohms
hi_drv3_6030   Driving, Z0=60-Ohms, Rload=30-Ohms
hi_drv3_6040   Driving, Z0=60-Ohms, Rload=40-Ohms
hi_drv3_6060   Driving, Z0=60-Ohms, Rload=60-Ohms
hi_drv3_60120   Driving, Z0=60-Ohms, Rload=120-Ohms
hi_rcv3_odt20   Receiving, ODT=20-Ohms
hi_rcv3_odt30   Receiving, ODT=30-Ohms
hi_rcv3_odt40   Receiving, ODT=40-Ohms
hi_rcv3_odt60   Receiving, ODT=60-Ohms
hi_rcv3_odt120   Receiving, ODT=120-Ohms
hi_rcv3_odtoff   Receiving, ODT=OFF
[Model Selector] PDDRSIO_ISOP
hi_drv3_3420   Driving, Z0=34-Ohms, Rload=20-Ohms
hi_drv3_3430   Driving, Z0=34-Ohms, Rload=30-Ohms
hi_drv3_3440   Driving, Z0=34-Ohms, Rload=40-Ohms
hi_drv3_3460   Driving, Z0=34-Ohms, Rload=60-Ohms
hi_drv3_34120   Driving, Z0=34-Ohms, Rload=120-Ohms
hi_drv3_4020   Driving, Z0=40-Ohms, Rload=20-Ohms
hi_drv3_4030   Driving, Z0=40-Ohms, Rload=30-Ohms
hi_drv3_4040   Driving, Z0=40-Ohms, Rload=40-Ohms
hi_drv3_4060   Driving, Z0=40-Ohms, Rload=60-Ohms
hi_drv3_40120   Driving, Z0=40-Ohms, Rload=120-Ohms
hi_drv3_6020   Driving, Z0=60-Ohms, Rload=20-Ohms
hi_drv3_6030   Driving, Z0=60-Ohms, Rload=30-Ohms
hi_drv3_6040   Driving, Z0=60-Ohms, Rload=40-Ohms
hi_drv3_6060   Driving, Z0=60-Ohms, Rload=60-Ohms
hi_drv3_60120   Driving, Z0=60-Ohms, Rload=120-Ohms
hi_rcv3_odt20   Receiving, ODT=20-Ohms
hi_rcv3_odt30   Receiving, ODT=30-Ohms
hi_rcv3_odt40   Receiving, ODT=40-Ohms
hi_rcv3_odt60   Receiving, ODT=60-Ohms
hi_rcv3_odt120   Receiving, ODT=120-Ohms
hi_rcv3_odtoff   Receiving, ODT=OFF
[Model Selector] PDDRDIO_IGOS
hi_drv3_3420   Driving, Z0=34-Ohms, Rload=20-Ohms
hi_drv3_3430   Driving, Z0=34-Ohms, Rload=30-Ohms
hi_drv3_3440   Driving, Z0=34-Ohms, Rload=40-Ohms
hi_drv3_3460   Driving, Z0=34-Ohms, Rload=60-Ohms
hi_drv3_34120   Driving, Z0=34-Ohms, Rload=120-Ohms
hi_drv3_4020   Driving, Z0=40-Ohms, Rload=20-Ohms
hi_drv3_4030   Driving, Z0=40-Ohms, Rload=30-Ohms
hi_drv3_4040   Driving, Z0=40-Ohms, Rload=40-Ohms
hi_drv3_4060   Driving, Z0=40-Ohms, Rload=60-Ohms
hi_drv3_40120   Driving, Z0=40-Ohms, Rload=120-Ohms
hi_drv3_6020   Driving, Z0=60-Ohms, Rload=20-Ohms
hi_drv3_6030   Driving, Z0=60-Ohms, Rload=30-Ohms
hi_drv3_6040   Driving, Z0=60-Ohms, Rload=40-Ohms
hi_drv3_6060   Driving, Z0=60-Ohms, Rload=60-Ohms
hi_drv3_60120   Driving, Z0=60-Ohms, Rload=120-Ohms
hi_rcv3_odt20   Receiving, ODT=20-Ohms
hi_rcv3_odt30   Receiving, ODT=30-Ohms
hi_rcv3_odt40   Receiving, ODT=40-Ohms
hi_rcv3_odt60   Receiving, ODT=60-Ohms
hi_rcv3_odt120   Receiving, ODT=120-Ohms
hi_rcv3_odtoff   Receiving, ODT=OFF
[Model Selector] PRDW4DCDG_L
io2_1ma   when DS1 & DS0& SR
io2_2ma   when DS1 & !DS0& SR
io2_3ma   when !DS1 & DS0& SR
io2_4ma   when !DS1 & !DS0& SR
[Model Selector] PRDW4DDGZ_L
io2_1ma   when DS1 & DS0& SR
io2_2ma   when DS1 & !DS0& SR
io2_3ma   when !DS1 & DS0& SR
io2_4ma   when !DS1 & !DS0& SR
[Model Selector] PRDW4DSCDG_L
io2_1ma   when DS1 & DS0& SR
io2_2ma   when DS1 & !DS0& SR
io2_3ma   when !DS1 & DS0& SR
io2_4ma   when !DS1 & !DS0& SR
[Model Selector] PRDW4DSDGZ_L
io2_1ma   when DS1 & DS0& SR
io2_2ma   when DS1 & !DS0& SR
io2_3ma   when !DS1 & DS0& SR
io2_4ma   when !DS1 & !DS0& SR
[Model Selector] PRUKW4DSCDG_L
io2_1ma   when DS1 & DS0& SR
io2_2ma   when DS1 & !DS0& SR
io2_3ma   when !DS1 & DS0& SR
io2_4ma   when !DS1 & !DS0& SR
[Model Selector] PRUW4DSCDG_L
io2_1ma   when DS1 & DS0& SR
io2_2ma   when DS1 & !DS0& SR
io2_3ma   when !DS1 & DS0& SR
io2_4ma   when !DS1 & !DS0& SR
[Model Selector] PRUW4DSDGZ_L
io2_1ma   when DS1 & DS0& SR
io2_2ma   when DS1 & !DS0& SR
io2_3ma   when !DS1 & DS0& SR
io2_4ma   when !DS1 & !DS0& SR
[Model Selector] PRDW8DCDG
io6_1ma   when DS2&DS1 & DS0& SR
io6_2ma   when DS2&DS1 & !DS0& SR
io6_4ma   when DS2&!DS1 & DS0& SR
io6_5ma   when DS2&!DS1 & !DS0& SR
io6_8ma   when !DS2&DS1 & DS0& !SR
io6_9ma   when !DS2&DS1 & !DS0& !SR
io6_11ma   when !DS2&!DS1 & DS0& !SR
io6_12ma   when !DS2&!DS1 & !DS0& !SR
io6_1v8_1ma   when DS2&DS1 & DS0& SR
io6_1v8_2ma   when DS2&DS1 & !DS0& SR
io6_1v8_4ma   when DS2&!DS1 & DS0& SR
io6_1v8_5ma   when DS2&!DS1 & !DS0& SR
io6_1v8_8ma   when !DS2&DS1 & DS0& !SR
io6_1v8_9ma   when !DS2&DS1 & !DS0& !SR
io6_1v8_11ma   when !DS2&!DS1 & DS0& !SR
io6_1v8_12ma   when !DS2&!DS1 & !DS0& !SR
[Model Selector] PRUKW8DCDG
io6_1ma   when DS2&DS1 & DS0& SR
io6_2ma   when DS2&DS1 & !DS0& SR
io6_4ma   when DS2&!DS1 & DS0& SR
io6_5ma   when DS2&!DS1 & !DS0& SR
io6_8ma   when !DS2&DS1 & DS0& !SR
io6_9ma   when !DS2&DS1 & !DS0& !SR
io6_11ma   when !DS2&!DS1 & DS0& !SR
io6_12ma   when !DS2&!DS1 & !DS0& !SR
io6_1v8_1ma   when DS2&DS1 & DS0& SR
io6_1v8_2ma   when DS2&DS1 & !DS0& SR
io6_1v8_4ma   when DS2&!DS1 & DS0& SR
io6_1v8_5ma   when DS2&!DS1 & !DS0& SR
io6_1v8_8ma   when !DS2&DS1 & DS0& !SR
io6_1v8_9ma   when !DS2&DS1 & !DS0& !SR
io6_1v8_11ma   when !DS2&!DS1 & DS0& !SR
io6_1v8_12ma   when !DS2&!DS1 & !DS0& !SR
[Model Selector] PRUW8DSCDG
io6_1ma   when DS2&DS1 & DS0& SR
io6_2ma   when DS2&DS1 & !DS0& SR
io6_4ma   when DS2&!DS1 & DS0& SR
io6_5ma   when DS2&!DS1 & !DS0& SR
io6_8ma   when !DS2&DS1 & DS0& !SR
io6_9ma   when !DS2&DS1 & !DS0& !SR
io6_11ma   when !DS2&!DS1 & DS0& !SR
io6_12ma   when !DS2&!DS1 & !DS0& !SR
io6_1v8_1ma   when DS2&DS1 & DS0& SR
io6_1v8_2ma   when DS2&DS1 & !DS0& SR
io6_1v8_4ma   when DS2&!DS1 & DS0& SR
io6_1v8_5ma   when DS2&!DS1 & !DS0& !SR
io6_1v8_8ma   when !DS2&DS1 & DS0& !SR
io6_1v8_9ma   when !DS2&DS1 & !DS0& !SR
io6_1v8_11ma   when !DS2&!DS1 & DS0& !SR
io6_1v8_12ma   when !DS2&!DS1 & !DS0& !SR
[Model Selector] PRDW8DCDG_H
io4_1ma   when DS2&DS1 & DS0& SR
io4_2ma   when DS2&DS1 & !DS0& SR
io4_4ma   when DS2&!DS1 & DS0& SR
io4_5ma   when DS2&!DS1 & !DS0& SR
io4_12ma   when !DS2&DS1 & DS0& !SR
io4_14ma   when !DS2&DS1 & !DS0& !SR
io4_16ma   when !DS2&!DS1 & DS0& !SR
io4_18ma   when !DS2&!DS1 & !DS0& !SR
io4_1v8_1ma   when DS2&DS1 & DS0& SR
io4_1v8_2ma   when DS2&DS1 & !DS0& SR
io4_1v8_4ma   when DS2&!DS1 & DS0& SR
io4_1v8_5ma   when DS2&!DS1 & !DS0& !SR
io4_1v8_12ma   when !DS2&DS1 & DS0& !SR
io4_1v8_14ma   when !DS2&DS1 & !DS0& !SR
io4_1v8_16ma   when !DS2&!DS1 & DS0& !SR
io4_1v8_18ma   when !DS2&!DS1 & !DS0& !SR
| Models and submodels in the file (59): hi_drv3_34120 (I/O), hi_drv3_3420 (I/O), hi_drv3_3430 (I/O), hi_drv3_3440 (I/O), hi_drv3_3460 (I/O), hi_drv3_40120 (I/O), hi_drv3_4020 (I/O), hi_drv3_4030 (I/O), hi_drv3_4040 (I/O), hi_drv3_4060 (I/O), hi_drv3_60120 (I/O), hi_drv3_6020 (I/O), hi_drv3_6030 (I/O), hi_drv3_6040 (I/O), hi_drv3_6060 (I/O), hi_rcv3_odt120 (Input), hi_rcv3_odt20 (Input), hi_rcv3_odt30 (Input), hi_rcv3_odt40 (Input), hi_rcv3_odt60 (Input), hi_rcv3_odtoff (Input), io2_1ma (I/O), io2_2ma (I/O), io2_3ma (I/O), io2_4ma (I/O), io6_1ma (I/O), io6_2ma (I/O), io6_4ma (I/O), io6_5ma (I/O), io6_8ma (I/O), io6_9ma (I/O), io6_11ma (I/O), io6_12ma (I/O), io6_1v8_1ma (I/O), io6_1v8_2ma (I/O), io6_1v8_4ma (I/O), io6_1v8_5ma (I/O), io6_1v8_8ma (I/O), io6_1v8_9ma (I/O), io6_1v8_11ma (I/O), io6_1v8_12ma (I/O), io4_1ma (I/O), io4_2ma (I/O), io4_4ma (I/O), io4_5ma (I/O), io4_12ma (I/O), io4_14ma (I/O), io4_16ma (I/O), io4_18ma (I/O), io4_1v8_1ma (I/O), io4_1v8_2ma (I/O), io4_1v8_4ma (I/O), io4_1v8_5ma (I/O), io4_1v8_12ma (I/O), io4_1v8_14ma (I/O), io4_1v8_16ma (I/O), io4_1v8_18ma (I/O), PX3RNC_XIN (Input), PX3RNC_XOUT (Output)
